* cp_mismatch_pvt2.spice -- the up and down CURRENTS behind the corner mismatch.
*
* cp_mismatch_pvt.spice reported up to +74 % mismatch at ff even with the trim.
* A percentage like that is either a real mismatch or a down-current that has
* collapsed toward zero, which makes (up-down)/avg meaningless -- the bias
* generator is a self-biased reference and can sit in a weak state at DC.
* Only the currents distinguish the two.  Wp = 1.8 only.
*
* The trim was chosen at tt / 27 C / 1.2 V, where it nulls the mismatch between
* vctrl 0.60 and 0.65 V.  Mismatch is channel-length modulation, which moves
* with temperature and supply as well as with vctrl, so a tt null says nothing
* about ss/125 C.  2.0 um is swept alongside for the before/after.
* mis_pct is (up - down)/avg; i(Vout1) is +up, i(Vout2) is -down.
* Explicit blocks, no `if` (trap 2.21).  DC only: seconds.
.control
pre_osdi /home/ttuser/pdk/ihp-sg13cmos5l/libs.tech/ngspice/osdi/psp103.osdi
pre_osdi /home/ttuser/pdk/ihp-sg13cmos5l/libs.tech/ngspice/osdi/psp103_nqs.osdi
pre_osdi /home/ttuser/pdk/ihp-sg13cmos5l/libs.tech/ngspice/osdi/r3_cmc.osdi
.endc
.lib /home/ttuser/pdk/ihp-sg13cmos5l/libs.tech/ngspice/models/cornerMOSlv.lib mos_tt
.lib /home/ttuser/pdk/ihp-sg13cmos5l/libs.tech/ngspice/models/cornerRES.lib  res_typ
.include ../netlists/blocks.inc
.include cp_p.inc
.global sub!
Vsub sub! 0 0
VDD Vdd 0 1.2
VSS Vss 0 0
Vout1 o1 0 0.6
Vup1  u1 0 1.2
Vdn1  d1 0 0
x1 Vdd Vdd Vss Vss o1 u1 d1 bn bp cp_p
Vout2 o2 0 0.6
Vup2  u2 0 0
Vdn2  d2 0 1.2
x2 Vdd Vdd Vss Vss o2 u2 d2 bn bp cp_p
x9 Vss Vss Vdd Vdd bn Vdd Vss bp tiny_pll_bias_gen
.control
alterparam Wp = 1.8
alterparam Ls = 1
reset
foreach tmp -40 27 125
 foreach vd 1.08 1.2 1.32
  set temp = $tmp
  alter VDD = $vd
  foreach vo 0.50 0.60 0.70
   alter Vout1 dc = $vo
   alter Vout2 dc = $vo
   op
   let p_temp = $tmp
   let p_vdd = $vd
   let p_vout = $vo
   let i_up_nA = 1e9*i(Vout1)
   let i_dn_nA = -1e9*i(Vout2)
   let bn = v(bn)
   let bp = v(bp)
   print p_temp p_vdd p_vout i_up_nA i_dn_nA bn bp
  end
 end
end
quit
.endc
.end
