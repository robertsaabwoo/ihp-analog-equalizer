* cp_charge.spice -- the charge one UP decision delivers vs one DOWN decision, pump alone.
*
* Why isolated: the loop runs away because the detector characteristic's phase-average is
* +77 nA at ff/-40 C against +10 nA at tt/125 C (pd_phase_*.log), i.e. an up decision and a
* down decision do not deliver equal and opposite charge.  That is a property of the pump,
* so measure the pump alone: fire one up pulse, then one down pulse, and integrate the
* charge into a held output.  Ideal pump: q_up + q_dn = 0.
*
* Sweep, not guesswork: the nMOS switch width and the up-path inverter's P/N ratio are the
* two things that set the difference (the up path has that inverter; the down path does
* not).  Each point is a 25 ns transient -- the whole grid costs less than one closed-loop
* run.  Run under sim/run_corners.sh.
.control
pre_osdi /home/ttuser/pdk/ihp-sg13cmos5l/libs.tech/ngspice/osdi/psp103.osdi
pre_osdi /home/ttuser/pdk/ihp-sg13cmos5l/libs.tech/ngspice/osdi/psp103_nqs.osdi
pre_osdi /home/ttuser/pdk/ihp-sg13cmos5l/libs.tech/ngspice/osdi/r3_cmc.osdi
.endc
.lib /home/ttuser/pdk/ihp-sg13cmos5l/libs.tech/ngspice/models/cornerMOSlv.lib mos_tt
.lib /home/ttuser/pdk/ihp-sg13cmos5l/libs.tech/ngspice/models/cornerRES.lib res_typ
.include cp_bias.inc
.include ../netlists/blocks.inc
.global sub!
Vsub sub! 0 0
VDD Vdd 0 1.2
VSS Vss 0 0
Iref Vdd vbias dc 40u
xref vbias Vss ibias_mirror
xb Vdd Vss vbias bn bp cp_bias

.param Wnsw=0.5 Winvp=2 Winvn=1 ui=1.665n
.subckt cp_t VPWR VPB VGND VNB out up down bias_n bias_p
XMNSRC src_n bias_n VGND VNB sg13_lv_nmos w=1u l=1u ng=1 m=1 mm_ok=1
XMNSW  out   down   src_n VNB sg13_lv_nmos w='Wnsw*1e-6' l=0.13u ng=1 m=1 mm_ok=1
XMPSW  out   upb    src_p VPB sg13_lv_pmos w=1u l=0.13u ng=1 m=1 mm_ok=1
XMPSRC src_p bias_p VPWR VPB sg13_lv_pmos w=1.8u l=1u ng=1 m=1 mm_ok=1
XMINVP upb   up     VPWR VPWR sg13_lv_pmos w='Winvp*1e-6' l=0.13u ng=1 m=1 mm_ok=1
XMINVN upb   up     VGND VGND sg13_lv_nmos w='Winvn*1e-6' l=0.13u ng=1 m=1 mm_ok=1
.ends

Vout o 0 dc 0.6
* one UP decision at 5 ns, one DOWN decision at 15 ns, each one UI wide
Vup  u 0 PULSE(0 1.2 5n  20p 20p 'ui' 100n)
Vdn  d 0 PULSE(0 1.2 15n 20p 20p 'ui' 100n)
x1 Vdd Vdd Vss Vss o u d bn bp cp_t

.control
foreach wn 0.4 0.5 0.6 0.7
 foreach ivp 1.0 1.5 2.0
  alterparam Wnsw = $wn
  alterparam Winvp = $ivp
  reset
  foreach tmp -40 27 125
   foreach vd 1.08 1.2 1.32
    set temp = $tmp
    alter VDD = $vd
    alter Vup PULSE(0 $vd 5n 20p 20p 1.665n 100n)
    alter Vdn PULSE(0 $vd 15n 20p 20p 1.665n 100n)
    alter Vout dc = 0.6
    tran 2p 25n uic
    meas tran q_up_fC INTEG i(Vout) FROM=4n  TO=14n
    meas tran q_dn_fC INTEG i(Vout) FROM=14n TO=24n
    let q_up_fC = q_up_fC*1e15
    let q_dn_fC = q_dn_fC*1e15
    let p_wn = $wn
    let p_ivp = $ivp
    let p_temp = $tmp
    let p_vdd = $vd
    print p_wn p_ivp p_temp p_vdd q_up_fC q_dn_fC
    echo ROWEND
   end
  end
 end
end
quit
.endc
.end
