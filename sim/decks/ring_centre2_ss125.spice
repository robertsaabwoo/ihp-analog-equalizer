* ring_centre2_ss125.spice -- can the ring be centred so the coarse trim works BOTH ways?
*
* Today the trim only speeds the ring up (RING_DUAL_LOOP.md 10.1), so the fast-cold corner
* pins the fine loop at the bottom of its range (1200 MHz/V, loop_scurve_ffm40.log) and the
* slow-hot corner has 0.35 % margin with the trim fully on (vco_ct_centre_ss125_108.log).
* Both ends are against a wall.
*
* The fix costs no new devices: make the ring SLOWER untrimmed (bigger Rload) and the trim
* STRONGER (wider pMOS), so the rest point sits mid-range and the trim can go both ways.
* SWEEP 2: the first grid capped vctrl at 0.70 V, but at the slow corner the loop
* legitimately runs vctrl high (0.9-1.05 V) where the ring is flat, so candidates were
* being scored against an artificially narrow window.  Wtr 8-12 um is also dropped:
* at ss/125 C/1.08 V the trim fully on with Wtr 8 stops the ring oscillating
* (swing 0.000, ring_centre_ss125.log).
* This sweep asks whether any (Rload, Wtr) does that at both extremes at once:
*   ff/-40 C/1.32 V: 600.6 MHz reached with the trim OFF at a mid-range vctrl
*   ss/125 C/1.08 V: 600.6 MHz reached with the trim ON  at a mid-range vctrl
* Ring only: ~4 minutes per corner, no closed loop.
.control
pre_osdi /home/ttuser/pdk/ihp-sg13cmos5l/libs.tech/ngspice/osdi/psp103.osdi
pre_osdi /home/ttuser/pdk/ihp-sg13cmos5l/libs.tech/ngspice/osdi/psp103_nqs.osdi
pre_osdi /home/ttuser/pdk/ihp-sg13cmos5l/libs.tech/ngspice/osdi/r3_cmc.osdi
.endc
.lib /home/ttuser/pdk/ihp-sg13cmos5l/libs.tech/ngspice/models/cornerMOSlv.lib mos_ss
.lib /home/ttuser/pdk/ihp-sg13cmos5l/libs.tech/ngspice/models/cornerRES.lib  res_typ
.lib /home/ttuser/pdk/ihp-sg13cmos5l/libs.tech/ngspice/models/cornerCAP.lib  cap_typ
* ring_ct.inc defines the ring; its output buffer (diff_amp_inv) is in blocks.inc.
.include ../netlists/blocks.inc
.include ring_ct.inc
.temp 125
.global sub!
Vsub sub! 0 0
VDD VDD 0 1.08
VSS VSS 0 0
Vc   vctrl   0 0.65
Vcrs vcoarse 0 1.08
x1 VDD VSS vctrl vcoarse vop vom ring_ct
.ic v(vop)=1.0 v(vom)=0.4
.options method=gear reltol=1e-4 abstol=1e-12 vntol=1e-6
.control
save v(vop) v(vom) v(x1.net1)
foreach rl 11000 12000 13000
 foreach wt 4 6
  alterparam Rload = $rl
  alterparam Wtr = $wt
  reset
  foreach trim 1.08 0
   alter Vcrs dc = $trim
   foreach vc 0.60 0.70 0.80 0.90 1.00 1.05
    alter Vc dc = $vc
    tran 5p 120n
    meas tran t1 when v(vop)=v(vom) rise=6
    meas tran t2 when v(vop)=v(vom) rise=26
    let f_MHz = 20/(t2-t1)/1e6
    meas tran vmax max v(x1.net1) from=60n to=120n
    meas tran vmin min v(x1.net1) from=60n to=120n
    let swing = vmax - vmin
    let p_rl = $rl
    let p_wt = $wt
    let p_trim = $trim
    let p_vc = $vc
    print p_rl p_wt p_trim p_vc f_MHz swing
    echo ROWEND
   end
  end
 end
end
quit
.endc
.end
