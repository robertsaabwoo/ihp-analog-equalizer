* vco_ct_floor.spice -- how slow can the trimmed ring go, and where does it die?
*
* The corner sweep reads the slow end of the knob space at a fixed vctrl of
* 0.45 V, which is a convention, not the floor.  At two corners that convention
* gives the wrong answer in opposite directions:
*
*   tt / 125 C / 1.32 V   oscillates at 605.1 MHz -- *above* the 600.6 MHz baud
*                         rate, so on that reading the ring cannot go slow
*                         enough and the corner fails
*   ss / any / any        does not oscillate at all at 0.45 V, so the sweep
*                         reports nothing and the corner looks unmeasured
*
* Both are the same artefact: 0.45 V is near the tail device's threshold, and
* where that sits relative to 0.45 V moves by a couple of hundred millivolts
* across process and temperature.  The floor that matters is the lowest
* frequency at which the ring still oscillates with a usable swing, so sweep
* vctrl down and find it, at the corners where the question is live.
*
* The filter is the ring node's own swing above 300 mV differential -- 150 mV
* single-ended -- which is the threshold docs/DESIGN.md uses everywhere else,
* and the reason it is read on the ring node and not on vop: the diff_amp_inv
* buffer is rail to rail whatever the ring does, so a dying ring still measures
* a healthy swing there.
.control
pre_osdi /home/ttuser/pdk/ihp-sg13cmos5l/libs.tech/ngspice/osdi/psp103.osdi
pre_osdi /home/ttuser/pdk/ihp-sg13cmos5l/libs.tech/ngspice/osdi/psp103_nqs.osdi
pre_osdi /home/ttuser/pdk/ihp-sg13cmos5l/libs.tech/ngspice/osdi/r3_cmc.osdi
pre_osdi /home/ttuser/pdk/ihp-sg13cmos5l/libs.tech/ngspice/osdi/cap_cmomf.osdi
.endc

.lib /home/ttuser/pdk/ihp-sg13cmos5l/libs.tech/ngspice/models/cornerMOSlv.lib mos_tt
.lib /home/ttuser/pdk/ihp-sg13cmos5l/libs.tech/ngspice/models/cornerRES.lib  res_typ
.lib /home/ttuser/pdk/ihp-sg13cmos5l/libs.tech/ngspice/models/cornerCAP.lib  cap_typ

.include ../netlists/blocks.inc
.include ring_ct.inc

.global sub!
Vsub sub! 0 0
VDD VDD 0 1.32
VSS VSS 0 0
Vc   vctrl   0 0.45
Vcrs vcoarse 0 1.32

x1 VDD VSS vctrl vcoarse vop vom ring_ct
.ic v(vop)=1.0 v(vom)=0.4
.options method=gear reltol=1e-4 abstol=1e-12 vntol=1e-6

.control
save v(vop) v(vom) v(x1.net1)
* The trim stays off throughout: this is the slow end of the range.
foreach tmp 125 27 -40
 foreach vd 1.32 1.08
  set temp = $tmp
  alter VDD  = $vd
  alter Vcrs dc = $vd
  foreach vc 0.50 0.45 0.42 0.39 0.36 0.33 0.30
   alter Vc dc = $vc
   tran 5p 160n
   let p_temp  = $tmp
   let p_vdd   = $vd
   let p_vctrl = $vc
   meas tran rmax max v(x1.net1) from=80n to=160n
   meas tran rmin min v(x1.net1) from=80n to=160n
   let swing = rmax - rmin
   meas tran t1 when v(vop)=v(vom) rise=6
   meas tran t2 when v(vop)=v(vom) rise=26
   let fosc = 20 / (t2 - t1)
   print p_temp p_vdd p_vctrl fosc swing
  end
 end
end
quit
.endc
.end
