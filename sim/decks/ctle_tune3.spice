* CTLE sizing search 3: sweep the INPUT COMMON MODE as well, to find out
* whether the tail can be given enough headroom to saturate at 1.2 V.
* (Derived from ctle_tune2 by tools; the loop below is what it actually runs.)
*
.control
pre_osdi /home/ttuser/pdk/ihp-sg13cmos5l/libs.tech/ngspice/osdi/psp103.osdi
pre_osdi /home/ttuser/pdk/ihp-sg13cmos5l/libs.tech/ngspice/osdi/psp103_nqs.osdi
pre_osdi /home/ttuser/pdk/ihp-sg13cmos5l/libs.tech/ngspice/osdi/r3_cmc.osdi
pre_osdi /home/ttuser/pdk/ihp-sg13cmos5l/libs.tech/ngspice/osdi/cap_cmomf.osdi
.endc

.lib /home/ttuser/pdk/ihp-sg13cmos5l/libs.tech/ngspice/models/cornerMOSlv.lib mos_tt
.lib /home/ttuser/pdk/ihp-sg13cmos5l/libs.tech/ngspice/models/cornerRES.lib  res_typ
.lib /home/ttuser/pdk/ihp-sg13cmos5l/libs.tech/ngspice/models/cornerCAP.lib  cap_typ

.include ctle_p.inc

.global sub!
Vsub sub! 0 0

.param vcm=0.75
.param cload=50f
.param rch=500 cch=5p

VDD  VDD 0 1.2
VSS  VSS 0 0
Vb   vbias 0 0.55

Vsp  srcp 0 dc 'vcm' ac 0.5 0
Vsm  srcm 0 dc 'vcm' ac 0.5 180
Rchp srcp inp 'rch'
Rchm srcm inm 'rch'
Cchp inp 0 'cch'
Cchm inm 0 'cch'

x1 outp outm inp inm VDD VSS vbias ctle_p
Clp outp 0 'cload'
Clm outm 0 'cload'

.options method=gear reltol=1e-4 abstol=1e-13 vntol=1e-7

.control
foreach vc 0.70 0.75 0.80 0.85
  foreach rl 5000 6400 8000
    alterparam Win   = 20
    alterparam Rload = $rl
    alterparam Wtail = 8
    alterparam Ltail = 1.0
    reset
    alter Vsp dc = $vc
    alter Vsm dc = $vc
    foreach vb 0.45 0.50 0.55 0.60 0.65
      alter Vb dc = $vb
      op
      let p_vcm    = $vc
      let p_rload  = $rl
      let p_vb     = $vb
      let itail    = -i(vdd)
      let voutcm   = v(outp)
      let vst      = v(x1.st)
      print p_vcm p_rload p_vb itail voutcm vst
      ac dec 20 1e6 1e10
      let gctle = db(v(outp) - v(outm)) - db(v(inp) - v(inm))
      let gtot  = db(v(outp) - v(outm)) - db(v(srcp) - v(srcm))
      meas ac gdc   find gctle at=1e6
      meas ac gnyq  find gctle at=3e8
      meas ac gsys  find gtot  at=3e8
      let boost = gnyq - gdc
      print gdc gnyq boost gsys
    end
  end
end
quit
.endc
.end
