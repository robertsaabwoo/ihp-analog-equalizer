* vco_ct_centre.spice -- where does the coarse trim have to sit at nominal?
*
* The corner sweep asks only whether 600.6 MHz lies between the two extremes of
* the knob space.  This asks the complementary question at tt / 27 C / 1.2 V:
* at what vcoarse does the ring hit the baud rate with vctrl at the middle of
* the fine range?  That number is what the closed-loop decks seed, so that a
* capture can be demonstrated in four microseconds of transient instead of the
* fifty the search would need from cold -- fifty microseconds of closed-loop
* CDR is several hours on this machine.
*
* It is also the number that says whether the trim is *centred*.  A trim whose
* nominal sits at either end has its range on one side only, and the corner
* sweep would still pass while half the silicon fell off the end.
.control
pre_osdi /home/ttuser/pdk/ihp-sg13cmos5l/libs.tech/ngspice/osdi/psp103.osdi
pre_osdi /home/ttuser/pdk/ihp-sg13cmos5l/libs.tech/ngspice/osdi/psp103_nqs.osdi
pre_osdi /home/ttuser/pdk/ihp-sg13cmos5l/libs.tech/ngspice/osdi/r3_cmc.osdi
pre_osdi /home/ttuser/pdk/ihp-sg13cmos5l/libs.tech/ngspice/osdi/cap_cmomf.osdi
.endc

.lib /home/ttuser/pdk/ihp-sg13cmos5l/libs.tech/ngspice/models/cornerMOSlv.lib mos_tt
.lib /home/ttuser/pdk/ihp-sg13cmos5l/libs.tech/ngspice/models/cornerRES.lib  res_typ
.lib /home/ttuser/pdk/ihp-sg13cmos5l/libs.tech/ngspice/models/cornerCAP.lib  cap_typ

.include ../netlists/blocks.inc
.include ring_ct.inc

.global sub!
Vsub sub! 0 0
VDD VDD 0 1.2
VSS VSS 0 0
Vc   vctrl   0 0.60
Vcrs vcoarse 0 1.2

x1 VDD VSS vctrl vcoarse vop vom ring_ct
.ic v(vop)=1.0 v(vom)=0.4
.options method=gear reltol=1e-4 abstol=1e-12 vntol=1e-6

.control
save v(vop) v(vom) v(x1.net1)
* Seeds for the coarse-loop closed-loop decks, at 0.025 V vctrl resolution.
* A 0.1 V grid over the steep part of this curve once gave a Kvco wrong by 2x;
* not again.  vcoarse = 1.20 (trim off, cross-checks the 0.595 V seed) and
* vcoarse = 0.55 (trim partly on, e2e_dual_walk's starting point).
* Seed at the worst mismatch corner, ff / 125 C / 1.32 V, so a closed-loop
* PRBS7 run there tests the consequence directly instead of trusting the DC
* mismatch percentage (+72 % with the trim) as a proxy for it.  At ff the ring
* is fast, so the coarse loop parks at its slow rail: trim OFF, vcoarse = VDD.
set temp = -40
alter Vcrs dc = 1.2
foreach vc 0.300 0.325 0.350 0.375 0.400 0.425 0.450 0.475 0.500 0.525 0.550 0.600 0.650
 alter Vc dc = $vc
 tran 5p 120n
 let p_vctrl = $vc
 meas tran t1 when v(vop)=v(vom) rise=6
 meas tran t2 when v(vop)=v(vom) rise=26
 let fosc = 20 / (t2 - t1)
 meas tran vmax max v(x1.net1) from=60n to=120n
 meas tran vmin min v(x1.net1) from=60n to=120n
 let swing = vmax - vmin
 print p_vctrl fosc swing
end
quit
.endc
.end
