* End-to-end acquisition on PRBS7 -- the run that decides whether the 0101
* numbers mean anything.
*
* An Alexander detector is blind during a run of identical bits: there is no
* data transition to compare the clock against.  PRBS7's longest run is seven
* unit intervals, so whatever the charge pump does when neither phase should
* be firing gets integrated for up to 11.7 ns at a stretch.  On 0101 that
* never happens.
*
* Two numbers make this the run to worry about here.  The pump's up/down
* mismatch measures 6.7 % (0.90 uA against 0.85 uA, cp_current.spice) where
* the sky130 original had 1.6 %, and mismatch is exactly what integrates over
* a blind run.  And that project found PRBS7 took 3x longer to settle than
* 0101 and left 2.8x the dither, so the window has to be long enough to prove
* settling rather than assume it.
*
*   PRBS7 data at 600.6 Mb/s, 200 mVpp differential
*     -> channel: 500 ohm series, 5 pF shunt on both legs (63.7 MHz pole)
*     -> the whole ctle_cdr_rx macro: CTLE, Alexander PD, charge pump,
*        loop filter, ring VCO, startup precharge, output buffers
*     -> recovered clock
*
* 0101 is the easiest input a bang-bang phase detector can be given: a
* transition every UI, so the detector is never blind. If the loop does not
* lock on this it will not lock on anything, which is why it is the first
* closed-loop run rather than PRBS7.
*
* 200 mVpp and not a rail-to-rail input on purpose: driven hard the CTLE
* limits instead of equalising, and the equalisation cannot show up in the
* measurement at all. The sky130 project spent a session on that.
*
* HEAVY: ~75000 timepoints over 225 devices, expect 10-20 minutes.
* Run only under tools/safe_ngspice.sh, and never alongside another ngspice.
.control
pre_osdi /home/ttuser/pdk/ihp-sg13cmos5l/libs.tech/ngspice/osdi/psp103.osdi
pre_osdi /home/ttuser/pdk/ihp-sg13cmos5l/libs.tech/ngspice/osdi/psp103_nqs.osdi
pre_osdi /home/ttuser/pdk/ihp-sg13cmos5l/libs.tech/ngspice/osdi/r3_cmc.osdi
pre_osdi /home/ttuser/pdk/ihp-sg13cmos5l/libs.tech/ngspice/osdi/cap_cmomf.osdi
.endc

.lib /home/ttuser/pdk/ihp-sg13cmos5l/libs.tech/ngspice/models/cornerMOSlv.lib mos_ff
.lib /home/ttuser/pdk/ihp-sg13cmos5l/libs.tech/ngspice/models/cornerRES.lib  res_typ
.lib /home/ttuser/pdk/ihp-sg13cmos5l/libs.tech/ngspice/models/cornerCAP.lib  cap_typ

.include ../netlists/blocks.inc

.temp 125
.global sub!
Vsub sub! 0 0
* Pin the coarse trim.  This deck measures the fine loop on its own, and with
* vcoarse! free the coarse loop corrects whatever this deck is detuning --
* silently, and every point passes.  0.60 V is the nominal trim point at
* tt / 27 C / 1.2 V: the trim fully OFF, which is where the coarse loop
* rests at nominal (docs/RING_DUAL_LOOP.md section 7.3).
.global vcoarse!
Vcrs vcoarse! 0 1.32

.options method=gear reltol=1e-3 abstol=1e-12

.param vcm=0.70         ; CTLE input common mode
.param amp=0.2          ; 200 mVpp differential at the source
.param rpad=500 cpad=5p ; the specified worst-case channel
.param ui=1.665n        ; 600.6 Mb/s

VDD Vdd 0 1.32
VSS Vss 0 0
Iref Vdd ibias 40u

* The pattern is generated by tools/gen_prbs.py and covers 3.312 us against a
* 3.0 us transient.  A PWL source holds its last value forever, so a pattern
* that runs out mid-transient measures the data source running out.
.include prbs7_3u.inc
Edinp dinp 0 vol='vcm + 0.5*amp*(v(draw)-0.5)'
Edinm dinm 0 vol='vcm - 0.5*amp*(v(draw)-0.5)'

Rpadp dinp cinp 'rpad'
Cpadp cinp 0    'cpad'
Rpadm dinm cinm 'rpad'
Cpadm cinm 0    'cpad'

x1 cinp cinm ibias clkoutp clkoutm Vdd Vss ctle_cdr_rx

* The startup precharge is a one-shot fired by an RC whose capacitor .op
* treats as an open circuit.  Without this the cell never fires, the control
* voltage starts at zero, the ring never starts, and the result looks like a
* broken circuit rather than a broken testbench.
.ic v(x1.x2.x20.nrc)=0

* Break the ring's symmetry, or it never starts.  All five stages sitting at
* the same voltage is a valid DC solution and the simulator has no noise to
* leave it with; real silicon starts on thermal noise.
*
* Without these two lines this deck runs to completion and reports a perfectly
* plausible-looking result: the CTLE equalises correctly, the control voltage
* settles to 0.661 V with 1 mV of ripple, and the recovered clock has a swing
* of 49 nanovolts.  The loop is not locked, it is asleep -- the control voltage
* is quiet precisely *because* there is no clock for the phase detector to
* compare against, so the charge pump never fires.  A settled control voltage
* is not evidence of lock on its own, which is why this deck measures the
* clock swing and the frequency separately.
*
* x1.x2.x1 is ctle_cdr_rx -> CDR -> ring_oscillator; net1 and net2 are the
* first stage's two outputs.
.ic v(x1.x2.x1.net1)=0.9 v(x1.x2.x1.net2)=0.3

* ... and seed the control voltage, or the kick above is wasted.
*
* The first attempt set only the ring nodes.  The operating point duly came
* out asymmetric -- net1 at 0.9 V, net2 at 0.3 V, the rest of the ring latched
* against the rails -- and the ring still did not start, because at t = 0 the
* loop filter is at zero volts, so the ring has no tail current and is simply
* off.  It stays off until the startup precharge releases at 76 ns, and by
* then the asymmetry has long since decayed to nothing.  The kick has to
* coincide with the ring being powered.
*
* Seeding the loop filter at 0.62 V -- roughly where the ring runs at the baud
* rate -- means the ring is running from the first timestep while the
* asymmetry is still there.  It is a testbench convenience and it does bypass
* the cold-start behaviour of the precharge cell, which therefore has to be
* tested separately rather than as a side effect of this run.
* 0.55 V, not 0.62 V.  The ring changed with the coarse loop -- 0.7 um input
* pair, 9000 ohm load -- and now reaches 641.6 MHz at vctrl = 0.60 and
* 562.1 MHz at 0.50 (vco_ct_centre.log), so the baud rate is at about 0.549 V.
* Seeding 0.62 V starts the ring 2.7 % fast, and a closed-loop run seeded
* outside the fine loop's capture range measures the seed: the first attempt
* came out at 666.6 MHz with vctrl climbing at 63 mV/us, which is the
* out-of-band signature of docs/RING_DUAL_LOOP.md section 2, not a lock.
.ic v(x1.x2.vctrl)=0.489

* Stage probe, ff/125C/1.32V: the ring core runs (1.9 V diff p-p) but clkoutp is flat.
* Average and p-p at each stage from ring core to output, 20-60 ns, before precharge release.
.control
save v(x1.x2.x1.net7) v(x1.x2.x1.net8) v(x1.x2.net3) v(x1.x2.net4) v(x1.x2.clkraw+) v(x1.x2.clkraw-) v(x1.x2.rclk+) v(x1.x2.rclk-) v(x1.x2.x4.net1) v(x1.x2.x1.x6.net1) v(clkoutp)
tran 20p 60n
meas tran ring7_avg AVG v(x1.x2.x1.net7) FROM=20n TO=60n
meas tran ring7_pp PP v(x1.x2.x1.net7) FROM=20n TO=60n
meas tran ring8_avg AVG v(x1.x2.x1.net8) FROM=20n TO=60n
meas tran ring8_pp PP v(x1.x2.x1.net8) FROM=20n TO=60n
meas tran rout3_avg AVG v(x1.x2.net3) FROM=20n TO=60n
meas tran rout3_pp PP v(x1.x2.net3) FROM=20n TO=60n
meas tran rout4_avg AVG v(x1.x2.net4) FROM=20n TO=60n
meas tran rout4_pp PP v(x1.x2.net4) FROM=20n TO=60n
meas tran craw_p_avg AVG v(x1.x2.clkraw+) FROM=20n TO=60n
meas tran craw_p_pp PP v(x1.x2.clkraw+) FROM=20n TO=60n
meas tran craw_m_avg AVG v(x1.x2.clkraw-) FROM=20n TO=60n
meas tran craw_m_pp PP v(x1.x2.clkraw-) FROM=20n TO=60n
meas tran rclk_p_avg AVG v(x1.x2.rclk+) FROM=20n TO=60n
meas tran rclk_p_pp PP v(x1.x2.rclk+) FROM=20n TO=60n
meas tran rclk_m_avg AVG v(x1.x2.rclk-) FROM=20n TO=60n
meas tran rclk_m_pp PP v(x1.x2.rclk-) FROM=20n TO=60n
meas tran x4tail_avg AVG v(x1.x2.x4.net1) FROM=20n TO=60n
meas tran x4tail_pp PP v(x1.x2.x4.net1) FROM=20n TO=60n
meas tran x6tail_avg AVG v(x1.x2.x1.x6.net1) FROM=20n TO=60n
meas tran x6tail_pp PP v(x1.x2.x1.x6.net1) FROM=20n TO=60n
meas tran clkout_avg AVG v(clkoutp) FROM=20n TO=60n
meas tran clkout_pp PP v(clkoutp) FROM=20n TO=60n
print ring7_avg ring7_pp
print ring8_avg ring8_pp
print rout3_avg rout3_pp
print rout4_avg rout4_pp
print craw_p_avg craw_p_pp
print craw_m_avg craw_m_pp
print rclk_p_avg rclk_p_pp
print rclk_m_avg rclk_m_pp
print x4tail_avg x4tail_pp
print x6tail_avg x6tail_pp
print clkout_avg clkout_pp
quit
.endc
.end
