* Ring sizing search 1: input pair CHANNEL LENGTH against load resistance,
* on the parameterised ring.  This is where the L^-1.9 trend comes from.
* (Derived from vco_range; the loop below is what it actually runs.)
*
.control
pre_osdi /home/ttuser/pdk/ihp-sg13cmos5l/libs.tech/ngspice/osdi/psp103.osdi
pre_osdi /home/ttuser/pdk/ihp-sg13cmos5l/libs.tech/ngspice/osdi/psp103_nqs.osdi
pre_osdi /home/ttuser/pdk/ihp-sg13cmos5l/libs.tech/ngspice/osdi/r3_cmc.osdi
pre_osdi /home/ttuser/pdk/ihp-sg13cmos5l/libs.tech/ngspice/osdi/cap_cmomf.osdi
.endc

.lib /home/ttuser/pdk/ihp-sg13cmos5l/libs.tech/ngspice/models/cornerMOSlv.lib mos_tt
.lib /home/ttuser/pdk/ihp-sg13cmos5l/libs.tech/ngspice/models/cornerRES.lib  res_typ
.lib /home/ttuser/pdk/ihp-sg13cmos5l/libs.tech/ngspice/models/cornerCAP.lib  cap_typ

.include ../netlists/blocks.inc
.include ring_p.inc

.global sub!
Vsub sub! 0 0

VDD VDD 0 1.2
VSS VSS 0 0
Vc  vctrl 0 0.6

x1 VDD VSS vctrl vop vom ring_p

* Break the ring's symmetry so it starts.
.ic v(vop)=1.0 v(vom)=0.4

.options method=gear reltol=1e-4 abstol=1e-12 vntol=1e-6

.control
* Only these two vectors are stored.  A bare `write` would keep every node at
* every timepoint and has previously exhausted this machine's memory.
save v(vop) v(vom) v(vctrl)
foreach lin 0.13 0.30 0.60
 foreach rl 2500 4000 5500
  alterparam Win   = 3
  alterparam Lin   = $lin
  alterparam Wtail = 9
  alterparam Rload = $rl
  reset
  foreach vc 0.50 0.70 0.90 1.10
   alter Vc dc = $vc
  * 120 ns is ~70 cycles at 600 MHz; the first 40 ns is discarded as startup.
  tran 5p 120n
   let p_lin   = $lin
   let p_rload = $rl
   let p_vctrl = $vc
  * Count rising crossings of the midpoint in the settled window and divide by
  * the elapsed time, rather than trusting a single period: a ring that is
  * still building amplitude gives a period that drifts, and one `meas trig/targ`
  * on an early edge reports that drift as the frequency.
  meas tran t1 when v(vop)=v(vom) rise=6
  meas tran t2 when v(vop)=v(vom) rise=26
  let fosc = 20 / (t2 - t1)
  meas tran vmax max v(vop) from=60n to=120n
  meas tran vmin min v(vop) from=60n to=120n
   let swing = vmax - vmin
  print p_lin p_rload p_vctrl fosc swing
  end
 end
end
quit
.endc
.end
