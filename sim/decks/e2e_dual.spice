* e2e_dual.spice -- the whole receiver with both loops closed.
*
* Same stimulus as e2e_lock.spice: 0101 at 600.6 Mb/s, 200 mVpp differential,
* through the specified worst-case channel, into the full macro.  The
* difference is that the ring now carries the coarse trim and the CDR carries
* the coarse loop, so `vcoarse` is a state variable of the simulation rather
* than a voltage source.
*
* WHAT THIS CAN AND CANNOT SHOW
*
* A search from cold covers 1.07 V at 19.6 mV/us, which is 54 us of simulated
* time.  The 1.5 us lock run already costs a quarter of an hour on this
* machine, so a cold acquisition is a multi-hour run and is not how this gets
* verified.  The search from cold is measured open-loop instead, in
* coarse_tb.spice, where it costs seconds; what has to be shown *here* is the
* part that only exists when both loops are closed -- that the coarse loop
* walks in and the fine loop captures, and that once captured the pair sit
* still and do not degrade the numbers the fine loop reaches on its own.
*
* So vcoarse is seeded, and `vc0` says how far off.  Two runs:
*
*   vc0 at the nominal trim point   the loops must not disturb each other, and
*                                   f, ripple and swing must match e2e_lock
*   vc0 about 60 mV above it        the ring starts too slow, vctrl rails up,
*                                   the coarse loop walks down, and the fine
*                                   loop captures -- about 3 us of search
*
* Seeding vcoarse is the same kind of testbench convenience as seeding vctrl
* in e2e_lock: it bypasses a startup behaviour, so that behaviour has to be
* tested separately rather than as a side effect of this run.  The cold start
* is in coarse_tb.spice (it parks at 1.185 V, the slow end).
.control
pre_osdi /home/ttuser/pdk/ihp-sg13cmos5l/libs.tech/ngspice/osdi/psp103.osdi
pre_osdi /home/ttuser/pdk/ihp-sg13cmos5l/libs.tech/ngspice/osdi/psp103_nqs.osdi
pre_osdi /home/ttuser/pdk/ihp-sg13cmos5l/libs.tech/ngspice/osdi/r3_cmc.osdi
pre_osdi /home/ttuser/pdk/ihp-sg13cmos5l/libs.tech/ngspice/osdi/cap_cmomf.osdi
.endc

.lib /home/ttuser/pdk/ihp-sg13cmos5l/libs.tech/ngspice/models/cornerMOSlv.lib mos_tt
.lib /home/ttuser/pdk/ihp-sg13cmos5l/libs.tech/ngspice/models/cornerRES.lib  res_typ
.lib /home/ttuser/pdk/ihp-sg13cmos5l/libs.tech/ngspice/models/cornerCAP.lib  cap_typ

.include ../netlists/blocks.inc

* vcoarse! is a global, like sub!: it is a quasi-dc bias rail on ten gates.
.global sub! vcoarse!
Vsub sub! 0 0

.options method=gear reltol=1e-3 abstol=1e-12

.param vcm=0.70         ; CTLE input common mode
.param amp=0.2          ; 200 mVpp differential at the source
.param rpad=500 cpad=5p ; the specified worst-case channel
.param ui=1.665n        ; 600.6 Mb/s
.param vc0=0.60         ; seed for the coarse trim; see the header
.param tend=2500n

VDD Vdd 0 1.2
VSS Vss 0 0
Iref Vdd ibias 40u

Vdraw draw 0 PULSE(0 1 0 10p 10p 'ui' '2*ui')
Edinp dinp 0 vol='vcm + 0.5*amp*(v(draw)-0.5)'
Edinm dinm 0 vol='vcm - 0.5*amp*(v(draw)-0.5)'

Rpadp dinp cinp 'rpad'
Cpadp cinp 0    'cpad'
Rpadm dinm cinm 'rpad'
Cpadm cinm 0    'cpad'

x1 cinp cinm ibias clkoutp clkoutm Vdd Vss ctle_cdr_rx

* The startup precharge is a one-shot fired by an RC whose capacitor .op
* treats as an open circuit; without this it never fires.
.ic v(x1.x2.x20.nrc)=0
* Break the ring's symmetry, or it never starts -- all five stages at the same
* voltage is a valid dc solution and the simulator has no noise to leave it.
.ic v(x1.x2.x1.net1)=0.9 v(x1.x2.x1.net2)=0.3
* ... and the ring needs tail current at t = 0 for that kick to survive.
.ic v(x1.x2.vctrl)=0.62
.ic v(vcoarse!)='vc0'

.control
save v(x1.x2.vctrl) v(vcoarse!) v(clkoutp) v(clkoutm) v(x1.eq_p) v(x1.eq_m)
+    v(cinp) v(cinm) v(x1.x2.x20.pre)
tran 20p 'tend'

let vctrl  = v(x1.x2.vctrl)
let vcrs   = v(vcoarse!)
let ctle_d = v(x1.eq_p) - v(x1.eq_m)

* Two separated windows, which must agree, before any number is quoted: a loop
* measured while it is still settling reports the settling.  See trap 2.11.
meas tran vctrl_e1   AVG vctrl FROM='tend-700n' TO='tend-600n'
meas tran vctrl_e2   AVG vctrl FROM='tend-100n' TO='tend'
meas tran vcrs_e1    AVG vcrs  FROM='tend-700n' TO='tend-600n'
meas tran vcrs_e2    AVG vcrs  FROM='tend-100n' TO='tend'
meas tran vctrl_lock AVG vctrl FROM='tend-200n' TO='tend-100n'
meas tran vctrl_ripp PP  vctrl FROM='tend-200n' TO='tend-100n'
meas tran rclk_swing PP  v(clkoutp) FROM='tend-200n' TO='tend-100n'
meas tran ctle_swing PP  ctle_d FROM='tend-200n' TO='tend-100n'

* Frequency over a long baseline, inside the settled region: a short window
* measures the bang-bang dither, not the frequency (trap 2.10b).
meas tran c500 WHEN v(clkoutp)=0.6 RISE=500
meas tran c850 WHEN v(clkoutp)=0.6 RISE=850
let f_long = 350/(c850-c500)/1e6
let f_err  = 100*(f_long - 600.60)/600.60
* How far the coarse loop walked, and whether it has stopped.
let vcrs_walk_mV  = (vcrs_e2 - $&vc0)*1e3
let vcrs_creep_mV = (vcrs_e2 - vcrs_e1)*1e3
print f_long f_err vctrl_lock vctrl_ripp rclk_swing ctle_swing
print vcrs_e1 vcrs_e2 vcrs_walk_mV vcrs_creep_mV vctrl_e1 vctrl_e2
wrdata ../results/e2e_dual.csv vctrl vcrs
quit
.endc
.end
