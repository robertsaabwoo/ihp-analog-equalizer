* Ring-VCO tuning range: frequency against control voltage, per PVT corner.
*
* This is the measurement that decided the sky130 design's one accepted
* limitation.  There, the ring reached 514-621 MHz at tt/27 C, and could not
* reach the 600.6 MHz baud rate at 125 C or at a 1.62 V supply -- the loop
* has no frequency acquisition of its own (a bang-bang phase detector is
* phase-only), so a ring that cannot reach the baud rate is a ring that never
* locks.  Six of eleven swept corners passed.
*
* The five stages are CML: an NMOS pair with poly load resistors and a tail
* device whose gate is vctrl, so raising vctrl raises the tail current and the
* frequency, until the stage stops being current-starved and becomes RC
* limited by its own load resistor -- above which more vctrl buys nothing.
* That ceiling is what failed at temperature on sky130.
*
* A ring does not start on its own in a transient with a symmetric initial
* condition: both legs sit at the same voltage, which is a valid DC solution.
* .ic on one node of the first stage breaks the symmetry.  See
* docs/SIMULATION_TRAPS.md.
.control
pre_osdi /home/ttuser/pdk/ihp-sg13cmos5l/libs.tech/ngspice/osdi/psp103.osdi
pre_osdi /home/ttuser/pdk/ihp-sg13cmos5l/libs.tech/ngspice/osdi/psp103_nqs.osdi
pre_osdi /home/ttuser/pdk/ihp-sg13cmos5l/libs.tech/ngspice/osdi/r3_cmc.osdi
pre_osdi /home/ttuser/pdk/ihp-sg13cmos5l/libs.tech/ngspice/osdi/cap_cmomf.osdi
.endc

.lib /home/ttuser/pdk/ihp-sg13cmos5l/libs.tech/ngspice/models/cornerMOSlv.lib mos_tt
.lib /home/ttuser/pdk/ihp-sg13cmos5l/libs.tech/ngspice/models/cornerRES.lib  res_typ
.lib /home/ttuser/pdk/ihp-sg13cmos5l/libs.tech/ngspice/models/cornerCAP.lib  cap_typ

.include ../netlists/blocks.inc
.include ring_p.inc

.global sub!
Vsub sub! 0 0

VDD VDD 0 1.2
VSS VSS 0 0
Vc  vctrl 0 0.6

x1 VDD VSS vctrl vop vom ring_p

* Break the ring's symmetry so it starts.
.ic v(vop)=1.0 v(vom)=0.4

.options method=gear reltol=1e-4 abstol=1e-12 vntol=1e-6

.control
* Only these two vectors are stored.  A bare `write` would keep every node at
* every timepoint and has previously exhausted this machine's memory.
save v(vop) v(vom) v(vctrl)
* Which vctrl puts each candidate ring at the baud rate?  The closed-loop decks
* must be seeded at the lock point of the ring they are testing; seeding one
* ring at another's measures the seed, which has already cost a run.
*
* The vctrl grid runs 0.30-1.20, not 0.45-0.75.  The narrow version covered
* main's ring (which locks at 0.595) and missed both of the others entirely:
* the 0.7 um pair is already at 624 MHz at vctrl = 0.45 and needs a LOWER
* control voltage to reach the baud rate, while the 9000 ohm load is still at
* 485 MHz at 0.75 and needs a higher one.  tools/pick_seed.py reported "baud
* not reachable" for both rather than extrapolating, which is the only reason
* that was obvious instead of becoming two more wrongly-seeded runs.
*
* Four explicit blocks and NO `if`.  The first version of this deck selected the
* configuration with `if $cfg = 0.9_7355` inside a foreach over strings, and
* ngspice's control-language `if` does not do string comparison -- every branch
* fell through, all four configurations ran with the last alterparam still in
* force, and the sweep returned four identical columns.  Identical columns are
* at least a loud failure; a partially-applied one would not have been.

* Where must the ring's CEILING be for the loop to hold?
*
* main locks with the baud rate at 95 % of its 632.9 MHz ceiling -- past the
* knee, Kvco ~283 MHz/V.  The 9000 ohm branch ring puts it at 80 % of a
* 753 MHz ceiling, on the steep rise, Kvco 1239 MHz/V, and does not hold.
* Raising the load lowers the ceiling and walks the operating point up the
* curve into the flat region.  This finds the load that puts the tt ceiling
* near 640 MHz with the 0.7 um pair.

alterparam Lin = 0.7
alterparam Rload = 10000
reset
echo "=== CONFIG Lin=0.7 Rload=10000"
foreach vc 0.40 0.45 0.50 0.55 0.60 0.65 0.70 0.80 0.90 1.00 1.20
 alter Vc dc = $vc
 tran 5p 120n
 let p_vctrl = $vc
 meas tran t1 when v(vop)=v(vom) rise=6
 meas tran t2 when v(vop)=v(vom) rise=26
 let fosc = 20 / (t2 - t1)
 meas tran rmax max v(x1.net1) from=60n to=120n
 meas tran rmin min v(x1.net1) from=60n to=120n
 let swing = rmax - rmin
 print p_vctrl fosc swing
end

alterparam Lin = 0.7
alterparam Rload = 11000
reset
echo "=== CONFIG Lin=0.7 Rload=11000"
foreach vc 0.40 0.45 0.50 0.55 0.60 0.65 0.70 0.80 0.90 1.00 1.20
 alter Vc dc = $vc
 tran 5p 120n
 let p_vctrl = $vc
 meas tran t1 when v(vop)=v(vom) rise=6
 meas tran t2 when v(vop)=v(vom) rise=26
 let fosc = 20 / (t2 - t1)
 meas tran rmax max v(x1.net1) from=60n to=120n
 meas tran rmin min v(x1.net1) from=60n to=120n
 let swing = rmax - rmin
 print p_vctrl fosc swing
end

alterparam Lin = 0.7
alterparam Rload = 12000
reset
echo "=== CONFIG Lin=0.7 Rload=12000"
foreach vc 0.40 0.45 0.50 0.55 0.60 0.65 0.70 0.80 0.90 1.00 1.20
 alter Vc dc = $vc
 tran 5p 120n
 let p_vctrl = $vc
 meas tran t1 when v(vop)=v(vom) rise=6
 meas tran t2 when v(vop)=v(vom) rise=26
 let fosc = 20 / (t2 - t1)
 meas tran rmax max v(x1.net1) from=60n to=120n
 meas tran rmin min v(x1.net1) from=60n to=120n
 let swing = rmax - rmin
 print p_vctrl fosc swing
end
quit
.endc
.end
