* CTLE reference-current trim at 27 C: fingering the tail (ng=8, needed to keep
* w/ng inside the PSP model's 10 um limit) changed the mirror ratio, because
* PSP's width-dependent terms and the diffusion geometry both follow w/ng
* rather than w.  At iref = 25 uA the tail current fell from 351 uA to 253 uA
* and the Nyquist gain with it, 13.17 dB to 12.10 dB.  This finds the reference
* current that puts the operating point back.
*
* Original header follows.
* CTLE frequency response across PVT, driven through the specified worst-case
* channel (500 ohm series, 5 pF shunt -- a 63.7 MHz pole, 13.7 dB of loss at
* the 300 MHz Nyquist frequency of 600.6 Mb/s data).
*
* The device under test is the netlist of xschem/CTLE.sch, not a hand-written
* copy of it: sim/netlists/blocks.inc comes straight out of xschem, so a
* schematic edit that is not reflected here cannot happen.
*
* The process corner is chosen by the three .lib lines below, which
* run_ctle_ac.sh rewrites per corner.  Note that unlike sky130 -- where the
* MOS and the R/C corners share one .lib file and cannot be selected
* independently through the stock sections (see docs/SIMULATION_TRAPS.md) --
* IHP ships cornerMOSlv, cornerRES and cornerCAP as separate files, so a
* corner here really is process x resistor x capacitor and not an approximation
* of one.
.control
pre_osdi /home/ttuser/pdk/ihp-sg13cmos5l/libs.tech/ngspice/osdi/psp103.osdi
pre_osdi /home/ttuser/pdk/ihp-sg13cmos5l/libs.tech/ngspice/osdi/psp103_nqs.osdi
pre_osdi /home/ttuser/pdk/ihp-sg13cmos5l/libs.tech/ngspice/osdi/r3_cmc.osdi
pre_osdi /home/ttuser/pdk/ihp-sg13cmos5l/libs.tech/ngspice/osdi/cap_cmomf.osdi
.endc

.lib /home/ttuser/pdk/ihp-sg13cmos5l/libs.tech/ngspice/models/cornerMOSlv.lib mos_tt
.lib /home/ttuser/pdk/ihp-sg13cmos5l/libs.tech/ngspice/models/cornerRES.lib  res_typ
.lib /home/ttuser/pdk/ihp-sg13cmos5l/libs.tech/ngspice/models/cornerCAP.lib  cap_typ

.include ../netlists/blocks.inc

.global sub!
Vsub sub! 0 0

.param vcm=0.70
.param iref=25u
.param cload=50f
.param rch=500 cch=5p

VDD  VDD 0 1.2
VSS  VSS 0 0
* Bias is a reference current now, not a voltage: ibias_mirror turns it into
* whatever gate voltage this corner needs.  See xschem/ibias_mirror.sch.
Iref VDD vbias 'iref'
xb   vbias VSS ibias_mirror

Vsp  srcp 0 dc 'vcm' ac 0.5 0
Vsm  srcm 0 dc 'vcm' ac 0.5 180
Rchp srcp inp 'rch'
Rchm srcm inm 'rch'
Cchp inp 0 'cch'
Cchm inm 0 'cch'

x1 outp outm inp inm VDD VSS vbias CTLE
Clp outp 0 'cload'
Clm outm 0 'cload'

.options method=gear reltol=1e-4 abstol=1e-13 vntol=1e-7

.control
foreach ir 25u 30u 35u 40u 45u
  foreach vdd 1.08 1.2 1.32
    set temp = 27
    alter Iref dc = $ir
    alter VDD = $vdd
    op
    let p_iref   = $ir
    let p_vdd    = $vdd
    let itail    = -i(vdd)
    let voutcm   = v(outp)
    * x1.net2 is the tail drain.  The node is unnamed in CTLE.sch, so xschem
    * auto-numbers it; if the schematic is redrawn, check the number against
    * sim/netlists/blocks.inc before trusting this line.  An earlier version
    * of this deck asked for v(x1.st), which does not exist, and ngspice's
    * response was to silently drop the whole print statement.
    let vst      = v(x1.net2)
    let vbias_v  = v(vbias)
    print p_iref p_vdd itail voutcm vst vbias_v
    ac dec 40 1e5 1e10
    let gctle = db(v(outp) - v(outm)) - db(v(inp) - v(inm))
    let gsysv = db(v(outp) - v(outm)) - db(v(srcp) - v(srcm))
    meas ac gdc   find gctle at=1e6
    meas ac gnyq  find gctle at=3e8
    meas ac gsys  find gsysv at=3e8
    let boost = gnyq - gdc
    print gdc gnyq boost gsys
  end
end
quit
.endc
.end
