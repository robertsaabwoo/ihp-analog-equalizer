* cp_steer.spice -- the same isolated charge test as cp_charge.spice, on a CURRENT-STEERING
* pump.  Identical harness, identical measurement, so the two logs compare directly.
*
* Why isolated: the loop runs away because the detector characteristic's phase-average is
* +77 nA at ff/-40 C against +10 nA at tt/125 C (pd_phase_*.log), i.e. an up decision and a
* down decision do not deliver equal and opposite charge.  That is a property of the pump,
* so measure the pump alone: fire one up pulse, then one down pulse, and integrate the
* charge into a held output.  Ideal pump: q_up + q_dn = 0.
*
* Sweep, not guesswork: the nMOS switch width and the up-path inverter's P/N ratio are the
* two things that set the difference (the up path has that inverter; the down path does
* not).  Each point is a 25 ns transient -- the whole grid costs less than one closed-loop
* run.  Run under sim/run_corners.sh.
.control
pre_osdi /home/ttuser/pdk/ihp-sg13cmos5l/libs.tech/ngspice/osdi/psp103.osdi
pre_osdi /home/ttuser/pdk/ihp-sg13cmos5l/libs.tech/ngspice/osdi/psp103_nqs.osdi
pre_osdi /home/ttuser/pdk/ihp-sg13cmos5l/libs.tech/ngspice/osdi/r3_cmc.osdi
.endc
.lib /home/ttuser/pdk/ihp-sg13cmos5l/libs.tech/ngspice/models/cornerMOSlv.lib mos_ss
.lib /home/ttuser/pdk/ihp-sg13cmos5l/libs.tech/ngspice/models/cornerRES.lib res_typ
.include cp_bias.inc
.include ../netlists/blocks.inc
.global sub!
Vsub sub! 0 0
VDD Vdd 0 1.2
VSS Vss 0 0
Iref Vdd vbias dc 40u
xref vbias Vss ibias_mirror
xb Vdd Vss vbias bn bp cp_bias

.param Wnsw=0.5 Winvp=2 Winvn=1 ui=1.665n Vamp=1.2
* `dump` is a PORT, not an internal node: an internal subckt node cannot be wired from
* the top level in ngspice (the first version did that and would have silently created
* a floating node).
.subckt cp_t VPWR VPB VGND VNB out up down bias_n bias_p dump
* CURRENT-STEERING variant.  Both sources conduct all the time; the switches steer their
* current between `out` and `dump`.  In the switched pump (blocks.inc) each source is turned
* off and on, so its source node (src_p/src_n) charges and discharges and dumps that charge
* into the output -- the per-decision imbalance the switched version cannot escape
* (0.43 fC worst as built, ~130 nA at the baud rate, docs/EXPERIMENTS.md 2.13).
*
* Cost in the real circuit, stated honestly: two extra switches, two local inverters, and a
* `dump` node that must sit at the same potential as vctrl or the Vds of the two paths
* differ.  Here `dump` is held by a testbench source at the same dc as `out`; in the macro
* it needs a replica bias, which is the part to design if this variant wins.
XMNSRC src_n bias_n VGND VNB sg13_lv_nmos w=1u l=1u ng=1 m=1 mm_ok=1
XMNSW  out   down   src_n VNB sg13_lv_nmos w='Wnsw*1e-6' l=0.13u ng=1 m=1 mm_ok=1
XMNSWD dump  downb  src_n VNB sg13_lv_nmos w='Wnsw*1e-6' l=0.13u ng=1 m=1 mm_ok=1
XMPSRC src_p bias_p VPWR VPB sg13_lv_pmos w=1.8u l=1u ng=1 m=1 mm_ok=1
XMPSW  out   upb    src_p VPB sg13_lv_pmos w=1u l=0.13u ng=1 m=1 mm_ok=1
XMPSWD dump  up     src_p VPB sg13_lv_pmos w=1u l=0.13u ng=1 m=1 mm_ok=1
XMINVP upb   up     VPWR VPWR sg13_lv_pmos w='Winvp*1e-6' l=0.13u ng=1 m=1 mm_ok=1
XMINVN upb   up     VGND VGND sg13_lv_nmos w='Winvn*1e-6' l=0.13u ng=1 m=1 mm_ok=1
XMINDP downb down   VPWR VPWR sg13_lv_pmos w='Winvp*1e-6' l=0.13u ng=1 m=1 mm_ok=1
XMINDN downb down   VGND VGND sg13_lv_nmos w='Winvn*1e-6' l=0.13u ng=1 m=1 mm_ok=1
.ends

Vout o 0 dc 0.6
Vdump dmp 0 dc 0.6
* one UP decision at 5 ns, one DOWN decision at 15 ns, each one UI wide
Vup  u 0 PULSE(0 'Vamp' 5n  20p 20p 'ui' 100n)
Vdn  d 0 PULSE(0 'Vamp' 15n 20p 20p 'ui' 100n)
x1 Vdd Vdd Vss Vss o u d bn bp dmp cp_t

.control
* `alter Vup PULSE(...)` is rejected by ngspice ("Only a single param - value pair
* supported") and silently leaves the old amplitude, so the gate drive stayed at 1.2 V
* while VDD moved.  The amplitude goes through a .param instead, and every point does
* alterparam + reset (reset re-parses, which is what makes the new value take).
foreach wn 0.4 0.5 0.6 0.7
 foreach ivp 1.0 1.5 2.0
  foreach tmp -40 27 125
   foreach vd 1.08 1.2 1.32
    alterparam Wnsw = $wn
    alterparam Winvp = $ivp
    alterparam Vamp = $vd
    reset
    set temp = $tmp
    alter VDD = $vd
    alter Vout dc = 0.6
    alter Vdump dc = 0.6
    tran 2p 25n uic
    meas tran q_up_fC INTEG i(Vout) FROM=4n  TO=14n
    meas tran q_dn_fC INTEG i(Vout) FROM=14n TO=24n
    let q_up_fC = q_up_fC*1e15
    let q_dn_fC = q_dn_fC*1e15
    let p_wn = $wn
    let p_ivp = $ivp
    let p_temp = $tmp
    let p_vdd = $vd
    print p_wn p_ivp p_temp p_vdd q_up_fC q_dn_fC
    echo ROWEND
   end
  end
 end
end
quit
.endc
.end
