* vco_ct_centre.spice -- where does the coarse trim have to sit at nominal?
*
* The corner sweep asks only whether 600.6 MHz lies between the two extremes of
* the knob space.  This asks the complementary question at tt / 27 C / 1.2 V:
* at what vcoarse does the ring hit the baud rate with vctrl at the middle of
* the fine range?  That number is what the closed-loop decks seed, so that a
* capture can be demonstrated in four microseconds of transient instead of the
* fifty the search would need from cold -- fifty microseconds of closed-loop
* CDR is several hours on this machine.
*
* It is also the number that says whether the trim is *centred*.  A trim whose
* nominal sits at either end has its range on one side only, and the corner
* sweep would still pass while half the silicon fell off the end.
.control
pre_osdi /home/ttuser/pdk/ihp-sg13cmos5l/libs.tech/ngspice/osdi/psp103.osdi
pre_osdi /home/ttuser/pdk/ihp-sg13cmos5l/libs.tech/ngspice/osdi/psp103_nqs.osdi
pre_osdi /home/ttuser/pdk/ihp-sg13cmos5l/libs.tech/ngspice/osdi/r3_cmc.osdi
pre_osdi /home/ttuser/pdk/ihp-sg13cmos5l/libs.tech/ngspice/osdi/cap_cmomf.osdi
.endc

.lib /home/ttuser/pdk/ihp-sg13cmos5l/libs.tech/ngspice/models/cornerMOSlv.lib mos_tt
.lib /home/ttuser/pdk/ihp-sg13cmos5l/libs.tech/ngspice/models/cornerRES.lib  res_typ
.lib /home/ttuser/pdk/ihp-sg13cmos5l/libs.tech/ngspice/models/cornerCAP.lib  cap_typ

.include ../netlists/blocks.inc
.include ring_ct.inc

.global sub!
Vsub sub! 0 0
VDD VDD 0 1.2
VSS VSS 0 0
Vc   vctrl   0 0.60
Vcrs vcoarse 0 1.2

x1 VDD VSS vctrl vcoarse vop vom ring_ct
.ic v(vop)=1.0 v(vom)=0.4
.options method=gear reltol=1e-4 abstol=1e-12 vntol=1e-6

.control
save v(vop) v(vom) v(x1.net1)
foreach vcrs 1.20 1.00 0.85 0.75 0.65 0.55 0.45 0.30 0.15
 alter Vcrs dc = $vcrs
 foreach vc 0.50 0.60 0.70
  alter Vc dc = $vc
  tran 5p 120n
  let p_vcrs  = $vcrs
  let p_vctrl = $vc
  meas tran t1 when v(vop)=v(vom) rise=6
  meas tran t2 when v(vop)=v(vom) rise=26
  let fosc = 20 / (t2 - t1)
  meas tran vmax max v(x1.net1) from=60n to=120n
  meas tran vmin min v(x1.net1) from=60n to=120n
  let swing = vmax - vmin
  print p_vcrs p_vctrl fosc swing
 end
end
quit
.endc
.end
