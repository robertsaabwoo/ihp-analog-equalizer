* e2e_dual.spice -- the whole receiver with both loops closed.
*
* Same stimulus as e2e_lock.spice: 0101 at 600.6 Mb/s, 200 mVpp differential,
* through the specified worst-case channel, into the full macro.  The
* difference is that the ring now carries the coarse trim and the CDR carries
* the coarse loop, so `vcoarse` is a state variable of the simulation rather
* than a voltage source.
*
* WHAT THIS CAN AND CANNOT SHOW
*
* A search from cold covers 1.07 V at 19.6 mV/us, which is 54 us of simulated
* time.  The 1.5 us lock run already costs a quarter of an hour on this
* machine, so a cold acquisition is a multi-hour run and is not how this gets
* verified.  The search from cold is measured open-loop instead, in
* coarse_tb.spice, where it costs seconds; what has to be shown *here* is the
* part that only exists when both loops are closed -- that the coarse loop
* walks in and the fine loop captures, and that once captured the pair sit
* still and do not degrade the numbers the fine loop reaches on its own.
*
* This variant is the HANDOVER test, and it is the one that only exists with
* both loops closed.
*
* vcoarse is seeded at 0.55 V -- trim partly on, ring faster than it rests at --
* and vctrl at the value that locks there.  The coarse loop's null is 0.59 V
* and vctrl will settle near 0.55, so the pull-up branch walks vcoarse *up*
* toward the rail; the ring slows; and the fine loop has to raise vctrl to keep
* the recovered clock on the data.  The question is whether it does, or whether
* the coarse loop walks the ring out from under it.
*
* 0.65 V of travel at 19 mV/us is 34 us and the run is 2.5, so this does not
* show the walk *finishing*.  It does not need to: what has to be true is that
* the clock stays on the data while vcoarse moves, and 47 mV of movement is
* plenty to see that or not see it.
*
* Seeding vcoarse is the same kind of testbench convenience as seeding vctrl
* in e2e_lock: it bypasses a startup behaviour, so that behaviour has to be
* tested separately rather than as a side effect of this run.  The cold start
* is in coarse_tb.spice (it parks at 1.185 V, the slow end).
.control
pre_osdi /home/ttuser/pdk/ihp-sg13cmos5l/libs.tech/ngspice/osdi/psp103.osdi
pre_osdi /home/ttuser/pdk/ihp-sg13cmos5l/libs.tech/ngspice/osdi/psp103_nqs.osdi
pre_osdi /home/ttuser/pdk/ihp-sg13cmos5l/libs.tech/ngspice/osdi/r3_cmc.osdi
pre_osdi /home/ttuser/pdk/ihp-sg13cmos5l/libs.tech/ngspice/osdi/cap_cmomf.osdi
.endc

.lib /home/ttuser/pdk/ihp-sg13cmos5l/libs.tech/ngspice/models/cornerMOSlv.lib mos_tt
.lib /home/ttuser/pdk/ihp-sg13cmos5l/libs.tech/ngspice/models/cornerRES.lib  res_typ
.lib /home/ttuser/pdk/ihp-sg13cmos5l/libs.tech/ngspice/models/cornerCAP.lib  cap_typ

.include ../netlists/blocks.inc

* vcoarse! is a global, like sub!: it is a quasi-dc bias rail on ten gates.
.global sub! vcoarse!
Vsub sub! 0 0

.options method=gear reltol=1e-3 abstol=1e-12

.param vcm=0.70         ; CTLE input common mode
.param amp=0.2          ; 200 mVpp differential at the source
.param rpad=500 cpad=5p ; the specified worst-case channel
.param ui=1.665n        ; 600.6 Mb/s
.param vc0=1.20         ; seed for the coarse trim; see the header
* No `tend` parameter.  `tran` and `meas` in the control section do not
* evaluate a quoted .param: `tran 20p 'tend'` is accepted, TSTOP comes out
* zero, and then every vector downstream of it is invalid -- a wall of
* "RHS ... invalid" that names the vectors and never mentions the cause.
* Literals below.

VDD Vdd 0 1.2
VSS Vss 0 0
Iref Vdd ibias 40u

Vdraw draw 0 PULSE(0 1 0 10p 10p 'ui' '2*ui')
Edinp dinp 0 vol='vcm + 0.5*amp*(v(draw)-0.5)'
Edinm dinm 0 vol='vcm - 0.5*amp*(v(draw)-0.5)'

Rpadp dinp cinp 'rpad'
Cpadp cinp 0    'cpad'
Rpadm dinm cinm 'rpad'
Cpadm cinm 0    'cpad'

x1 cinp cinm ibias clkoutp clkoutm Vdd Vss ctle_cdr_rx

* The startup precharge is a one-shot fired by an RC whose capacitor .op
* treats as an open circuit; without this it never fires.
.ic v(x1.x2.x20.nrc)=0
* Break the ring's symmetry, or it never starts -- all five stages at the same
* voltage is a valid dc solution and the simulator has no noise to leave it.
.ic v(x1.x2.x1.net1)=0.9 v(x1.x2.x1.net2)=0.3
* ... and the ring needs tail current at t = 0 for that kick to survive.
*
* 0.55 V, not the 0.62 V e2e_lock uses.  The ring is a different ring: with the
* 0.7 um input pair and the 9000 ohm load it reaches 641.6 MHz at vctrl = 0.60
* and 562.1 MHz at 0.50 (vco_ct_centre.log), so 600.6 MHz is at about 0.549 V.
*
* The first run of this deck seeded 0.57 V, which is 617 MHz -- 2.7 % fast --
* and it did not lock: the recovered clock came out at 666.6 MHz with vctrl
* climbing at 63 mV/us, which is exactly the out-of-band signature of section 2
* of docs/RING_DUAL_LOOP.md.  Seeding a closed-loop deck outside the fine
* loop's capture range measures the seed.
.ic v(x1.x2.vctrl)=0.55
* A literal, not 'vc0': .ic does not evaluate expressions, and a quoted one
* is accepted and ignored, which starts the trim at zero volts -- the ring
* at its fastest -- and looks like a circuit that cannot lock.
.ic v(vcoarse!)=0.55

.control
save v(x1.x2.vctrl) v(vcoarse!) v(clkoutp) v(clkoutm) v(x1.eq_p) v(x1.eq_m)
+    v(cinp) v(cinm) v(x1.x2.x20.pre)
tran 20p 2500n

let vctrl  = v(x1.x2.vctrl)
let vcrs   = v(vcoarse!)
let ctle_d = v(x1.eq_p) - v(x1.eq_m)

* Two separated windows, which must agree, before any number is quoted: a loop
* measured while it is still settling reports the settling.  See trap 2.11.
meas tran vctrl_e1   AVG vctrl FROM=1800n TO=1900n
meas tran vctrl_e2   AVG vctrl FROM=2400n TO=2500n
meas tran vcrs_e1    AVG vcrs  FROM=1800n TO=1900n
meas tran vcrs_e2    AVG vcrs  FROM=2400n TO=2500n
meas tran vctrl_lock AVG vctrl FROM=2300n TO=2400n
meas tran vctrl_ripp PP  vctrl FROM=2300n TO=2400n
meas tran rclk_swing PP  v(clkoutp) FROM=2300n TO=2400n
meas tran ctle_swing PP  ctle_d FROM=2300n TO=2400n

* Frequency over a long baseline, inside the settled region: a short window
* measures the bang-bang dither, not the frequency (trap 2.10b).
meas tran c500 WHEN v(clkoutp)=0.6 RISE=500
meas tran c850 WHEN v(clkoutp)=0.6 RISE=850
let f_long = 350/(c850-c500)/1e6
let f_err  = 100*(f_long - 600.60)/600.60
* How far the coarse loop walked, and whether it has stopped.
let vcrs_walk_mV  = (vcrs_e2 - 0.55)*1e3
let vcrs_creep_mV = (vcrs_e2 - vcrs_e1)*1e3
print f_long f_err vctrl_lock vctrl_ripp rclk_swing ctle_swing
print vcrs_e1 vcrs_e2 vcrs_walk_mV vcrs_creep_mV vctrl_e1 vctrl_e2
wrdata ../results/e2e_dual_walk.csv vctrl vcrs
quit
.endc
.end
