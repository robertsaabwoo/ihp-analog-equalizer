* Ring-VCO tuning range: frequency against control voltage, per PVT corner.
*
* This is the measurement that decided the sky130 design's one accepted
* limitation.  There, the ring reached 514-621 MHz at tt/27 C, and could not
* reach the 600.6 MHz baud rate at 125 C or at a 1.62 V supply -- the loop
* has no frequency acquisition of its own (a bang-bang phase detector is
* phase-only), so a ring that cannot reach the baud rate is a ring that never
* locks.  Six of eleven swept corners passed.
*
* The five stages are CML: an NMOS pair with poly load resistors and a tail
* device whose gate is vctrl, so raising vctrl raises the tail current and the
* frequency, until the stage stops being current-starved and becomes RC
* limited by its own load resistor -- above which more vctrl buys nothing.
* That ceiling is what failed at temperature on sky130.
*
* A ring does not start on its own in a transient with a symmetric initial
* condition: both legs sit at the same voltage, which is a valid DC solution.
* .ic on one node of the first stage breaks the symmetry.  See
* docs/SIMULATION_TRAPS.md.
.control
pre_osdi /home/ttuser/pdk/ihp-sg13cmos5l/libs.tech/ngspice/osdi/psp103.osdi
pre_osdi /home/ttuser/pdk/ihp-sg13cmos5l/libs.tech/ngspice/osdi/psp103_nqs.osdi
pre_osdi /home/ttuser/pdk/ihp-sg13cmos5l/libs.tech/ngspice/osdi/r3_cmc.osdi
pre_osdi /home/ttuser/pdk/ihp-sg13cmos5l/libs.tech/ngspice/osdi/cap_cmomf.osdi
.endc

.lib /home/ttuser/pdk/ihp-sg13cmos5l/libs.tech/ngspice/models/cornerMOSlv.lib mos_tt
.lib /home/ttuser/pdk/ihp-sg13cmos5l/libs.tech/ngspice/models/cornerRES.lib  res_typ
.lib /home/ttuser/pdk/ihp-sg13cmos5l/libs.tech/ngspice/models/cornerCAP.lib  cap_typ

.include ../netlists/blocks.inc
.include ring_ct.inc

.global sub!
Vsub sub! 0 0

VDD VDD 0 1.2
VSS VSS 0 0
Vc  vctrl 0 0.6

Vcrs vcoarse 0 1.2
x1 VDD VSS vctrl vcoarse vop vom ring_ct

* Break the ring's symmetry so it starts.
.ic v(vop)=1.0 v(vom)=0.4

.options method=gear reltol=1e-4 abstol=1e-12 vntol=1e-6

.control
* Only these two vectors are stored.  A bare `write` would keep every node at
* every timepoint and has previously exhausted this machine's memory.
save v(vop) v(vom) v(vctrl) v(x1.net1)
* Sweep the coarse trim against the fine control.  What matters is whether the
* union of the vctrl ranges, across vcoarse, spans the 1.25:1 the corner sweep
* demands -- and whether each vcoarse setting still oscillates cleanly.
* The first pass of this sweep used one trim width (0.5 um) and got only
* +5.6 %, while vco_rsweep.spice showed a *resistor* of the same dc-equivalent
* value worth about +13 %.  The difference is that a pMOS across the load is
* only a resistor while it stays in triode: at the bottom of the ring's swing
* its source-drain voltage approaches its overdrive, it turns into a current
* source, and it stops helping the rising edge -- which is the edge the RC
* ceiling is made of.  So the width has to be swept, not calculated.
foreach wtr 1 2 4 8
 alterparam Wtr = $wtr
 reset
 foreach vcrs 1.20 0.70 0.50 0.30 0.00
  alter Vcrs dc = $vcrs
  foreach vc 1.10
   alter Vc dc = $vc
  * 120 ns is ~70 cycles at 600 MHz; the first 40 ns is discarded as startup.
  tran 5p 120n
   let p_wtr   = $wtr
   let p_vcrs  = $vcrs
   let p_vctrl = $vc
  * Count rising crossings of the midpoint in the settled window and divide by
  * the elapsed time, rather than trusting a single period: a ring that is
  * still building amplitude gives a period that drifts, and one `meas trig/targ`
  * on an early edge reports that drift as the frequency.
  meas tran t1 when v(vop)=v(vom) rise=6
  meas tran t2 when v(vop)=v(vom) rise=26
  let fosc = 20 / (t2 - t1)
  meas tran vmax max v(x1.net1) from=60n to=120n
  meas tran vmin min v(x1.net1) from=60n to=120n
   let swing = vmax - vmin
  print p_wtr p_vcrs p_vctrl fosc swing
  end
 end
end
quit
.endc
.end
