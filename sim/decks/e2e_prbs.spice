* End-to-end acquisition on PRBS7 -- the run that decides whether the 0101
* numbers mean anything.
*
* An Alexander detector is blind during a run of identical bits: there is no
* data transition to compare the clock against.  PRBS7's longest run is seven
* unit intervals, so whatever the charge pump does when neither phase should
* be firing gets integrated for up to 11.7 ns at a stretch.  On 0101 that
* never happens.
*
* Two numbers make this the run to worry about here.  The pump's up/down
* mismatch measures 6.7 % (0.90 uA against 0.85 uA, cp_current.spice) where
* the sky130 original had 1.6 %, and mismatch is exactly what integrates over
* a blind run.  And that project found PRBS7 took 3x longer to settle than
* 0101 and left 2.8x the dither, so the window has to be long enough to prove
* settling rather than assume it.
*
*   PRBS7 data at 600.6 Mb/s, 200 mVpp differential
*     -> channel: 500 ohm series, 5 pF shunt on both legs (63.7 MHz pole)
*     -> the whole ctle_cdr_rx macro: CTLE, Alexander PD, charge pump,
*        loop filter, ring VCO, startup precharge, output buffers
*     -> recovered clock
*
* 0101 is the easiest input a bang-bang phase detector can be given: a
* transition every UI, so the detector is never blind. If the loop does not
* lock on this it will not lock on anything, which is why it is the first
* closed-loop run rather than PRBS7.
*
* 200 mVpp and not a rail-to-rail input on purpose: driven hard the CTLE
* limits instead of equalising, and the equalisation cannot show up in the
* measurement at all. The sky130 project spent a session on that.
*
* HEAVY: ~75000 timepoints over 225 devices, expect 10-20 minutes.
* Run only under tools/safe_ngspice.sh, and never alongside another ngspice.
.control
pre_osdi /home/ttuser/pdk/ihp-sg13cmos5l/libs.tech/ngspice/osdi/psp103.osdi
pre_osdi /home/ttuser/pdk/ihp-sg13cmos5l/libs.tech/ngspice/osdi/psp103_nqs.osdi
pre_osdi /home/ttuser/pdk/ihp-sg13cmos5l/libs.tech/ngspice/osdi/r3_cmc.osdi
pre_osdi /home/ttuser/pdk/ihp-sg13cmos5l/libs.tech/ngspice/osdi/cap_cmomf.osdi
.endc

.lib /home/ttuser/pdk/ihp-sg13cmos5l/libs.tech/ngspice/models/cornerMOSlv.lib mos_tt
.lib /home/ttuser/pdk/ihp-sg13cmos5l/libs.tech/ngspice/models/cornerRES.lib  res_typ
.lib /home/ttuser/pdk/ihp-sg13cmos5l/libs.tech/ngspice/models/cornerCAP.lib  cap_typ

.include ../netlists/blocks.inc

.global sub!
Vsub sub! 0 0
* Pin the coarse trim.  This deck measures the fine loop on its own, and with
* vcoarse! free the coarse loop corrects whatever this deck is detuning --
* silently, and every point passes.  0.60 V is the nominal trim point at
* tt / 27 C / 1.2 V (sim/results/vco_ct_centre.log).
.global vcoarse!
Vcrs vcoarse! 0 0.60

.options method=gear reltol=1e-3 abstol=1e-12

.param vcm=0.70         ; CTLE input common mode
.param amp=0.2          ; 200 mVpp differential at the source
.param rpad=500 cpad=5p ; the specified worst-case channel
.param ui=1.665n        ; 600.6 Mb/s

VDD Vdd 0 1.2
VSS Vss 0 0
Iref Vdd ibias 40u

* The pattern is generated by tools/gen_prbs.py and covers 3.312 us against a
* 3.0 us transient.  A PWL source holds its last value forever, so a pattern
* that runs out mid-transient measures the data source running out.
.include prbs7_3u.inc
Edinp dinp 0 vol='vcm + 0.5*amp*(v(draw)-0.5)'
Edinm dinm 0 vol='vcm - 0.5*amp*(v(draw)-0.5)'

Rpadp dinp cinp 'rpad'
Cpadp cinp 0    'cpad'
Rpadm dinm cinm 'rpad'
Cpadm cinm 0    'cpad'

x1 cinp cinm ibias clkoutp clkoutm Vdd Vss ctle_cdr_rx

* The startup precharge is a one-shot fired by an RC whose capacitor .op
* treats as an open circuit.  Without this the cell never fires, the control
* voltage starts at zero, the ring never starts, and the result looks like a
* broken circuit rather than a broken testbench.
.ic v(x1.x2.x20.nrc)=0

* Break the ring's symmetry, or it never starts.  All five stages sitting at
* the same voltage is a valid DC solution and the simulator has no noise to
* leave it with; real silicon starts on thermal noise.
*
* Without these two lines this deck runs to completion and reports a perfectly
* plausible-looking result: the CTLE equalises correctly, the control voltage
* settles to 0.661 V with 1 mV of ripple, and the recovered clock has a swing
* of 49 nanovolts.  The loop is not locked, it is asleep -- the control voltage
* is quiet precisely *because* there is no clock for the phase detector to
* compare against, so the charge pump never fires.  A settled control voltage
* is not evidence of lock on its own, which is why this deck measures the
* clock swing and the frequency separately.
*
* x1.x2.x1 is ctle_cdr_rx -> CDR -> ring_oscillator; net1 and net2 are the
* first stage's two outputs.
.ic v(x1.x2.x1.net1)=0.9 v(x1.x2.x1.net2)=0.3

* ... and seed the control voltage, or the kick above is wasted.
*
* The first attempt set only the ring nodes.  The operating point duly came
* out asymmetric -- net1 at 0.9 V, net2 at 0.3 V, the rest of the ring latched
* against the rails -- and the ring still did not start, because at t = 0 the
* loop filter is at zero volts, so the ring has no tail current and is simply
* off.  It stays off until the startup precharge releases at 76 ns, and by
* then the asymmetry has long since decayed to nothing.  The kick has to
* coincide with the ring being powered.
*
* Seeding the loop filter at 0.62 V -- roughly where the ring runs at the baud
* rate -- means the ring is running from the first timestep while the
* asymmetry is still there.  It is a testbench convenience and it does bypass
* the cold-start behaviour of the precharge cell, which therefore has to be
* tested separately rather than as a side effect of this run.
.ic v(x1.x2.vctrl)=0.62

.control
* Explicit save list.  A bare `write` stores every node at every timepoint and
* is what exhausted this machine's memory once already.
save v(x1.x2.vctrl) v(clkoutp) v(clkoutm) v(x1.eq_p) v(x1.eq_m)
+    v(cinp) v(cinm) v(x1.x2.x20.pre)
tran 20p 3000n

let vctrl  = v(x1.x2.vctrl)
let ctle_d = v(x1.eq_p) - v(x1.eq_m)
let cin_d  = v(cinp) - v(cinm)

* Did it lock?  Three separate questions: the control voltage has settled,
* the recovered clock is a real full-swing clock, and its frequency is the
* baud rate.  Any one of them alone can look right while the loop is broken.
* Settling is proved inside the deck, not assumed: three separated averaging
* windows that must agree.  The sky130 project quoted a phase-error number
* from a window in which the control voltage was still drifting, and the
* figure was a measurement of convergence rather than of jitter.
meas tran vctrl_s1   AVG vctrl FROM=1500n TO=1700n
meas tran vctrl_s2   AVG vctrl FROM=2100n TO=2300n
meas tran vctrl_s3   AVG vctrl FROM=2700n TO=2900n
meas tran vctrl_lock AVG vctrl FROM=2700n TO=2900n
meas tran vctrl_ripp PP  vctrl FROM=2700n TO=2900n
* Peak excursion over the whole settled half: a run of identical bits lets the
* pump's mismatch integrate, and that shows up as an excursion beyond the
* cycle-to-cycle ripple rather than as ripple itself.
meas tran vctrl_max  MAX vctrl FROM=1500n TO=3000n
meas tran vctrl_min  MIN vctrl FROM=1500n TO=3000n
meas tran rclk_swing PP  v(clkoutp) FROM=2700n TO=2900n
meas tran t_release  WHEN v(x1.x2.x20.pre)=0.6 FALL=1

meas tran cin_swing  PP cin_d  FROM=2700n TO=2900n
meas tran ctle_swing PP ctle_d FROM=2700n TO=2900n

* Frequency over 60 cycles inside the settled window.  Counting many cycles
* rather than measuring one period: a loop that is still acquiring gives a
* period that drifts, and a single-period measurement reports that drift as
* the frequency.  The edge indices are chosen well inside the window -- a
* .measure on an edge index that does not exist fails silently, taking every
* `let` derived from it with it.
meas tran c600 WHEN v(clkoutp)=0.6 RISE=1000
meas tran c660 WHEN v(clkoutp)=0.6 RISE=1060
let f_MHz = 60/(c660-c600)/1e6

* A second estimate over a much longer baseline.  60 cycles is not enough to
* average out the control-voltage dither: with 177 mV of ripple on a 310 MHz/V
* oscillator the instantaneous frequency swings by tens of MHz, and a 60-cycle
* window reports a sample of that rather than the mean.  350 cycles, entirely
* inside the settled region, is the number to compare against the data rate.
* 700 cycles, entirely in the settled half.  At 600 MHz a 3 us run holds about
* 1800 edges; 1000 and 1700 are safely inside that, and a .measure on an edge
* index that does not exist fails silently and takes every derived `let` with it.
meas tran c500 WHEN v(clkoutp)=0.6 RISE=1000
meas tran c850 WHEN v(clkoutp)=0.6 RISE=1700
let f_long = 700/(c850-c500)/1e6
let f_err = 100*(f_long - 600.60)/600.60
print f_MHz f_long f_err
print vctrl_s1 vctrl_s2 vctrl_s3 vctrl_lock vctrl_ripp vctrl_max vctrl_min rclk_swing ctle_swing cin_swing
quit
.endc
.end
