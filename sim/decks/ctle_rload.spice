* CTLE final sizing sweep: LOAD RESISTANCE against reference current, across
* supply, on the parameterised copy.  This is the run that chose 3.5 kohm.
* (Derived from ctle_op; the loop below is what it actually runs.)
*
.control
pre_osdi /home/ttuser/pdk/ihp-sg13cmos5l/libs.tech/ngspice/osdi/psp103.osdi
pre_osdi /home/ttuser/pdk/ihp-sg13cmos5l/libs.tech/ngspice/osdi/psp103_nqs.osdi
pre_osdi /home/ttuser/pdk/ihp-sg13cmos5l/libs.tech/ngspice/osdi/r3_cmc.osdi
pre_osdi /home/ttuser/pdk/ihp-sg13cmos5l/libs.tech/ngspice/osdi/cap_cmomf.osdi
.endc

.lib /home/ttuser/pdk/ihp-sg13cmos5l/libs.tech/ngspice/models/cornerMOSlv.lib mos_tt
.lib /home/ttuser/pdk/ihp-sg13cmos5l/libs.tech/ngspice/models/cornerRES.lib  res_typ
.lib /home/ttuser/pdk/ihp-sg13cmos5l/libs.tech/ngspice/models/cornerCAP.lib  cap_typ

.include ctle_p.inc
.include ../netlists/blocks.inc

.global sub!
Vsub sub! 0 0

.param vcm=0.85
.param iref=43u
.param cload=50f
.param rch=500 cch=5p

VDD  VDD 0 1.2
VSS  VSS 0 0
* Bias is a reference current now, not a voltage: ibias_mirror turns it into
* whatever gate voltage this corner needs.  See xschem/ibias_mirror.sch.
Iref VDD vbias 'iref'
xb   vbias VSS ibias_mirror

Vsp  srcp 0 dc 'vcm' ac 0.5 0
Vsm  srcm 0 dc 'vcm' ac 0.5 180
Rchp srcp inp 'rch'
Rchm srcm inm 'rch'
Cchp inp 0 'cch'
Cchm inm 0 'cch'

x1 outp outm inp inm VDD VSS vbias ctle_p
Clp outp 0 'cload'
Clm outm 0 'cload'

.options method=gear reltol=1e-4 abstol=1e-13 vntol=1e-7

.control
foreach rl 2500 3000 3500 4000
  foreach ir 25u 30u
   alterparam Win = 30
   alterparam Lin = 0.2
   alterparam Wtail = 40
   alterparam Ltail = 1.0
   alterparam Rload = $rl
   alterparam Rdeg = 900
   alterparam Ccap = 1600f
   reset
   alter Vsp dc = 0.70
   alter Vsm dc = 0.70
   foreach vdd 1.08 1.2 1.32
    alter Iref dc = $ir
    alter VDD = $vdd
    op
    let p_rload  = $rl
    let p_iref   = $ir
    let p_vdd    = $vdd
    let itail    = -i(vdd)
    let voutcm   = v(outp)
    * x1.net2 is the tail drain.  The node is unnamed in CTLE.sch, so xschem
    * auto-numbers it; if the schematic is redrawn, check the number against
    * sim/netlists/blocks.inc before trusting this line.  An earlier version
    * of this deck asked for v(x1.st), which does not exist, and ngspice's
    * response was to silently drop the whole print statement.
    let vst      = v(x1.st)
    let vbias_v  = v(vbias)
    print p_rload p_iref p_vdd itail voutcm vst vbias_v
    ac dec 40 1e5 1e10
    let gctle = db(v(outp) - v(outm)) - db(v(inp) - v(inm))
    let gsysv = db(v(outp) - v(outm)) - db(v(srcp) - v(srcm))
    meas ac gdc   find gctle at=1e6
    meas ac gnyq  find gctle at=3e8
    meas ac gsys  find gsysv at=3e8
    let boost = gnyq - gdc
    print gdc gnyq boost gsys
   end
  end
end
quit
.endc
.end
